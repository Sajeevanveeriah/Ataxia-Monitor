* Diagnostic sensitivity study; not a manufacturer SPICE model.
* TH=0: original assumed 3.3V thresholds 1.7V/1.0V.
* TH=1/2: TI SN74LVC3G17 datasheet p5 min/min and max/max thresholds at 3.0V.
* These two valid pairs are examples, not exhaustive correlated PVT corners.
.param TH=0 PH=0 GAP=5m
.param SUPPLY={table(TH,0,3.3,1,3.0,2,3.0)}
.param VTP={table(TH,0,1.7,1,1.5,2,1.87)}
.param VTM={table(TH,0,1.0,1,0.84,2,1.14)}
.step param TH list 0 1 2
.step param PH 0 330 30
.step param GAP list 5m 10m 15m 20m 25m
V33 vdd 0 {SUPPLY}
Vmains mains 0 SINE(0 {230*sqrt(2)} 50 0 0 {PH})
Cc mains pin 100p
Cstray pin 0 30p
Scontact pin 0 contact 0 SCON
Vcontact contact 0 PWL(0 0 140m 0 140.001m 1 160m 1 160.001m 0
+ {160m+GAP} 0 {160.001m+GAP} 1 {180m+GAP} 1 {180.001m+GAP} 0)
.model SCON SW(Ron=1 Roff=1e12 Vt=0.5 Vh=0)
RS pin in 10k
RPU vdd in 360k
Cfilter in 0 27n
A7 in 0 0 0 0 0 out 0 SCHMITT Vt={(VTP+VTM)/2} Vh={(VTP-VTM)/2} Vhigh={SUPPLY} Vlow=0 Trise=2n Tfall=2n
.save V(in) V(out) V(pin) I(Scontact)
.options plotwinsize=0
.tran 0 270m 0 20u
.end
